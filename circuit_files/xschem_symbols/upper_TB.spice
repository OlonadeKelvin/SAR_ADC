** sch_path: /foss/designs/upper_TB.sch
**.subckt upper_TB
x1 VDD CLK_SH V1n notCLK_SH Vinn 0 V1p Vinp simp_SH
x2 VDD CLK_comp Von Vop VR VL V1p V1n 0 simple_comparator
V2 notCLK_SH 0 PULSE(0 3.3 215n 1n 1n 500n 1000n)
V5 Vinn net1 sin(0 -1.65 200000)
V6 net1 0 1.65
V7 Vinp net1 sin(0 1.65 200000)
V3 CLK_SH 0 PULSE(0 3.3 0 1n 1n 200n 1000n)
XC1 V1p P9 cap_cmim w=7.0e-6 l=7.0e-6 m=256 mm_ok=1
XC5 V1p P8 cap_cmim w=7.0e-6 l=7.0e-6 m=128 mm_ok=1
XC2 V1p P7 cap_cmim w=7.0e-6 l=7.0e-6 m=64 mm_ok=1
XC3 V1p P6 cap_cmim w=7.0e-6 l=7.0e-6 m=32 mm_ok=1
XC4 V1p P5 cap_cmim w=7.0e-6 l=7.0e-6 m=16 mm_ok=1
XC6 V1p P4 cap_cmim w=7.0e-6 l=7.0e-6 m=8 mm_ok=1
XC7 V1p P3 cap_cmim w=7.0e-6 l=7.0e-6 m=4 mm_ok=1
XC8 V1p P2 cap_cmim w=7.0e-6 l=7.0e-6 m=2 mm_ok=1
XC9 V1p P1 cap_cmim w=7.0e-6 l=7.0e-6 m=1 mm_ok=1
XC10 V1p P0 cap_cmim w=7.0e-6 l=7.0e-6 m=1 mm_ok=1
XC11 V1n N9 cap_cmim w=7.0e-6 l=7.0e-6 m=256 mm_ok=1
XC12 V1n N8 cap_cmim w=7.0e-6 l=7.0e-6 m=128 mm_ok=1
XC13 V1n N7 cap_cmim w=7.0e-6 l=7.0e-6 m=64 mm_ok=1
XC14 V1n N6 cap_cmim w=7.0e-6 l=7.0e-6 m=32 mm_ok=1
XC15 V1n N5 cap_cmim w=7.0e-6 l=7.0e-6 m=16 mm_ok=1
XC16 V1n N4 cap_cmim w=7.0e-6 l=7.0e-6 m=8 mm_ok=1
XC17 V1n N3 cap_cmim w=7.0e-6 l=7.0e-6 m=4 mm_ok=1
XC18 V1n N2 cap_cmim w=7.0e-6 l=7.0e-6 m=2 mm_ok=1
XC19 V1n N1 cap_cmim w=7.0e-6 l=7.0e-6 m=1 mm_ok=1
XC20 V1n N0 cap_cmim w=7.0e-6 l=7.0e-6 m=1 mm_ok=1
V4 CLK_outputAll 0 PULSE(0 3.3 950n 1n 1n 5n 1000n)
V9 CLK_resetOut 0 PULSE(0 3.3 1100n 1n 1n 10n 1000n)
V1 VDD 0 3.3
x4 VDD Valid Von Vop 0 simp_OR
x3 VDD notCLK_SH Valid 0 Ck2 Ck8 Ck3 Ck9 Ck1 Ck0 Ck4 Ck6 Ck7 Ck5 CLK_SH CLK_SH Vop CLK_comp net2 net3 net5 net4 net6 net7 net8
+ net9 net10 net11 Von net12 net13 net14 net15 net16 net17 net21 net20 net19 net18 P9_out P8_out P7_out P6_out P5_out P4_out P3_out
+ P2_out P1_out P0_out CLK_outputAll CLK_resetOut N9_out N8_out N7_out N6_out N5_out N4_out N3_out N2_out N1_out N0_out DFF_array2
x5 VDD P9 net2 P8 net3 P7 net5 P6 net4 P5 net6 net7 P4 P3 net8 net9 P2 net10 P1 P0 net11 0 capDrivers
x6 VDD N9 net12 N8 net13 N7 net14 N6 net15 N5 net16 net17 N4 N3 net21 net20 N2 net19 N1 N0 net18 0 capDrivers
**** begin user architecture code

** IHP models
.lib cornerMOSlv.lib mos_tt
.lib cornerMOShv.lib mos_tt
.lib cornerHBT.lib hbt_typ
.lib cornerRES.lib res_typ
.lib cornerCAP.lib cap_typ

.param temp=27

.save v(CLK_SH) v(notCLK_SH) v(CLK_outputAll) v(CLK_resetOut)
.save v(Vinp) v(Vinn) v(v1p) v(V1n)
.save v(Von) v(Vop) v(Valid)
.save v(Ck9) v(Ck8) v(Ck7) v(Ck6) v(Ck5) v(Ck4) v(Ck3) v(Ck2) v(Ck1) v(Ck0)
.save v(P9) v(P8) v(P7) v(P6) v(P5) v(P4) v(P3) v(P2) v(P1) v(P0)
.save v(N9) v(N8) v(N7) v(N6) v(N5) v(N4) v(N3) v(N2) v(N1) v(N0)
.save v(P9_out) v(P8_out) v(P7_out) v(P6_out) v(P5_out) v(P4_out) v(P3_out) v(P2_out) v(P1_out) v(P0_out)
.save v(N9_out) v(N8_out) v(N7_out) v(N6_out) v(N5_out) v(N4_out) v(N3_out) v(N2_out) v(N1_out) v(N0_out)

.ic v(x1.clk_pnot) = 0
.tran 0.05n 2300n

.control
set num_threads 1
run
write testWhole.raw
.endc

**** end user architecture code
**.ends

* expanding   symbol:  simp_SH.sym # of pins=8
** sym_path: /foss/designs/simp_SH.sym
** sch_path: /foss/designs/simp_SH.sch
.subckt simp_SH VDD_samp CLK Voutn _CLK Vinn VSS_samp Voutp Vinp
*.ipin CLK
*.ipin _CLK
*.iopin VDD_samp
*.iopin VSS_samp
*.ipin Vinn
*.opin Voutn
*.ipin Vinp
*.opin Voutp
XM3 CLK_pnot CLK VSS_samp VSS_samp sg13_hv_nmos w=0.3u l=0.45u ng=1 m=1 mm_ok=1
XM1 CLK_pnot CLK VDD_samp VDD_samp sg13_hv_pmos w=0.3u l=0.4u ng=1 m=1 mm_ok=1
XM2 Cap_pbot _CLK VSS_samp VSS_samp sg13_hv_nmos w=0.3u l=0.45u ng=1 m=1 mm_ok=1
XM5 Cap_ptop net1 VDD_samp VDD_samp sg13_hv_pmos w=0.3u l=0.4u ng=1 m=1 mm_ok=1
XM6 net1 CLK_pnot Cap_ptop VDD_samp sg13_hv_pmos w=0.3u l=0.4u ng=1 m=1 mm_ok=1
XM7 CLK_pnot net1 Cap_pbot VSS_samp sg13_hv_nmos w=0.3u l=0.45u ng=1 m=1 mm_ok=1
XM8 net2 VDD_samp net1 VSS_samp sg13_hv_nmos w=0.3u l=0.45u ng=1 m=1 mm_ok=1
XM9 VSS_samp _CLK net2 VSS_samp sg13_hv_nmos w=0.3u l=0.45u ng=1 m=1 mm_ok=1
XM10 Vinn net1 Cap_pbot VSS_samp sg13_hv_nmos w=0.3u l=0.45u ng=1 m=10 mm_ok=1
XM12 CLK_nnot CLK VSS_samp VSS_samp sg13_hv_nmos w=0.3u l=0.45u ng=1 m=1 mm_ok=1
XM13 CLK_nnot CLK VDD_samp VDD_samp sg13_hv_pmos w=0.3u l=0.4u ng=1 m=1 mm_ok=1
XM14 Cap_nbot _CLK VSS_samp VSS_samp sg13_hv_nmos w=0.3u l=0.45u ng=1 m=1 mm_ok=1
XM16 Cap_ntop net3 VDD_samp VDD_samp sg13_hv_pmos w=0.3u l=0.4u ng=1 m=1 mm_ok=1
XM17 net3 CLK_nnot Cap_ntop VDD_samp sg13_hv_pmos w=0.3u l=0.4u ng=1 m=1 mm_ok=1
XM18 CLK_nnot net3 Cap_nbot VSS_samp sg13_hv_nmos w=0.3u l=0.45u ng=1 m=1 mm_ok=1
XM19 net4 VDD_samp net3 VSS_samp sg13_hv_nmos w=0.3u l=0.45u ng=1 m=1 mm_ok=1
XM20 VSS_samp _CLK net4 VSS_samp sg13_hv_nmos w=0.3u l=0.45u ng=1 m=1 mm_ok=1
XM21 Vinp net3 Cap_nbot VSS_samp sg13_hv_nmos w=0.3u l=0.45u ng=1 m=10 mm_ok=1
XC1 Cap_ntop Cap_nbot cap_cmim w=7.0e-6 l=7.0e-6 m=8 mm_ok=1
XC2 Cap_ptop Cap_pbot cap_cmim w=7.0e-6 l=7.0e-6 m=8 mm_ok=1
XM4 Voutp net3 Vinp VSS_samp sg13_lv_nmos w=0.15u l=0.13u ng=1 m=20 mm_ok=1
XM11 Voutn net1 Vinn VSS_samp sg13_lv_nmos w=0.15u l=0.13u ng=1 m=20 mm_ok=1
.ends

* expanding   symbol:  simple_comparator.sym # of pins=9
** sym_path: /foss/designs/simple_comparator.sym
** sch_path: /foss/designs/simple_comparator.sch
.subckt simple_comparator VDD_comparator CLK Voutn Voutp Debug_NC_Vright_gm Debug_NC_Vleft_gm Vinp Vinn VSS_comparator
*.ipin CLK
*.ipin Vinp
*.iopin VSS_comparator
*.iopin VDD_comparator
*.ipin Vinn
*.opin Debug_NC_Vright_gm
*.opin Debug_NC_Vleft_gm
*.opin Voutp
*.opin Voutn
XM1 Voutp Voutn VDD_comparator VDD_comparator sg13_hv_pmos w=0.3u l=0.4u ng=1 m=1 mm_ok=1
XM2 Debug_NC_Vleft_gm Vinp VS_dp VSS_comparator sg13_hv_nmos w=0.3u l=0.45u ng=1 m=1 mm_ok=1
XM3 Voutp Voutn Debug_NC_Vleft_gm VSS_comparator sg13_hv_nmos w=0.3u l=0.45u ng=1 m=1 mm_ok=1
XM4 Debug_NC_Vright_gm Vinn VS_dp VSS_comparator sg13_hv_nmos w=0.3u l=0.45u ng=1 m=1 mm_ok=1
XM5 Voutn Voutp Debug_NC_Vright_gm VSS_comparator sg13_hv_nmos w=0.3u l=0.45u ng=1 m=1 mm_ok=1
XM6 Voutn Voutp VDD_comparator VDD_comparator sg13_hv_pmos w=0.3u l=0.4u ng=1 m=1 mm_ok=1
XM7 VS_dp CLK VSS_comparator VSS_comparator sg13_hv_nmos w=0.3u l=0.45u ng=1 m=1 mm_ok=1
XM8 Voutn CLK VDD_comparator VDD_comparator sg13_hv_pmos w=0.3u l=0.4u ng=1 m=1 mm_ok=1
XM9 Voutp CLK VDD_comparator VDD_comparator sg13_hv_pmos w=0.3u l=0.4u ng=1 m=1 mm_ok=1
.ends

* expanding   symbol:  simp_OR.sym # of pins=5
** sym_path: /foss/designs/simp_OR.sym
** sch_path: /foss/designs/simp_OR.sch
.subckt simp_OR VDD_OR OR_out B A VSS_OR
*.iopin VDD_OR
*.iopin VSS_OR
*.opin OR_out
*.ipin B
*.ipin A
XM2 net2 B VDD_OR VDD_OR sg13_hv_pmos w=0.3u l=0.4u ng=1 m=1 mm_ok=1
XM3 net1 A net2 VDD_OR sg13_hv_pmos w=0.3u l=0.4u ng=1 m=1 mm_ok=1
XM4 net1 A VSS_OR VSS_OR sg13_hv_nmos w=0.3u l=0.45u ng=1 m=1 mm_ok=1
XM6 net1 B VSS_OR VSS_OR sg13_hv_nmos w=0.3u l=0.45u ng=1 m=1 mm_ok=1
XM7 OR_out net1 VDD_OR VDD_OR sg13_hv_pmos w=0.3u l=0.4u ng=1 m=1 mm_ok=1
XM8 OR_out net1 VSS_OR VSS_OR sg13_hv_nmos w=0.3u l=0.45u ng=1 m=1 mm_ok=1
.ends

* expanding   symbol:  DFF_array2.sym # of pins=61
** sym_path: /foss/designs/DFF_array2.sym
** sch_path: /foss/designs/DFF_array2.sch
.subckt DFF_array2 VDD_array CompB Valid_DFF VSS_array Ck2 Ck8 Ck3 Ck9 Ck1 Ck0 Ck4 Ck6 Ck7 Ck5 Comp Reset_decision Comp_outP
+ CLK_comp P9_cap P8_cap P7_cap P6_cap P5_cap P4_cap P3_cap P2_cap P1_cap P0_cap Comp_outN N9_cap N8_cap N7_cap N6_cap N5_cap N4_cap N3_cap
+ N2_cap N1_cap N0_cap P9_out P8_out P7_out P6_out P5_out P4_out P3_out P2_out P1_out P0_out Output_all Rst_output_DFFs N9_out N8_out
+ N7_out N6_out N5_out N4_out N3_out N2_out N1_out N0_out
*.opin P0_cap
*.opin P9_cap
*.opin P8_cap
*.opin P7_cap
*.opin P6_cap
*.opin P5_cap
*.opin P3_cap
*.opin P1_cap
*.opin P4_cap
*.opin N9_cap
*.opin N0_cap
*.opin P2_cap
*.opin N7_cap
*.opin N8_cap
*.opin N5_cap
*.opin N6_cap
*.opin N3_cap
*.opin N4_cap
*.opin N1_cap
*.opin N2_cap
*.opin P9_out
*.opin P8_out
*.opin P7_out
*.opin P6_out
*.opin P5_out
*.opin P4_out
*.opin P2_out
*.opin P0_out
*.opin P1_out
*.opin P3_out
*.opin N9_out
*.opin N7_out
*.opin N5_out
*.opin N3_out
*.opin N1_out
*.opin N8_out
*.opin N6_out
*.opin N4_out
*.opin N2_out
*.opin N0_out
*.iopin VDD_array
*.ipin CompB
*.ipin Valid_DFF
*.iopin VSS_array
*.ipin Comp_outP
*.ipin Comp_outN
*.ipin Output_all
*.ipin Rst_output_DFFs
*.opin CLK_comp
*.iopin Reset_decision
*.ipin Comp
*.opin Ck9
*.opin Ck8
*.opin Ck7
*.opin Ck6
*.opin Ck5
*.opin Ck4
*.opin Ck3
*.opin Ck2
*.opin Ck1
*.opin Ck0
x11 VDD_array Reset_decision P9_cap Comp_outP Ck9 VSS_array simp_DFF
x12 VDD_array Reset_decision P8_cap Comp_outP Ck8 VSS_array simp_DFF
x13 VDD_array Reset_decision P7_cap Comp_outP Ck7 VSS_array simp_DFF
x14 VDD_array Reset_decision P6_cap Comp_outP Ck6 VSS_array simp_DFF
x15 VDD_array Reset_decision P5_cap Comp_outP Ck5 VSS_array simp_DFF
x16 VDD_array Reset_decision P4_cap Comp_outP Ck4 VSS_array simp_DFF
x17 VDD_array Reset_decision P3_cap Comp_outP Ck3 VSS_array simp_DFF
x18 VDD_array Reset_decision P2_cap Comp_outP Ck2 VSS_array simp_DFF
x19 VDD_array Reset_decision P1_cap Comp_outP Ck1 VSS_array simp_DFF
x20 VDD_array Reset_decision P0_cap Comp_outP Ck0 VSS_array simp_DFF
x41 VDD_array Rst_output_DFFs N9_out N9_cap Output_all VSS_array simp_DFF
x42 VDD_array Rst_output_DFFs N8_out N8_cap Output_all VSS_array simp_DFF
x43 VDD_array Rst_output_DFFs N7_out N7_cap Output_all VSS_array simp_DFF
x44 VDD_array Rst_output_DFFs N6_out N6_cap Output_all VSS_array simp_DFF
x45 VDD_array Rst_output_DFFs N5_out N5_cap Output_all VSS_array simp_DFF
x46 VDD_array Rst_output_DFFs N4_out N4_cap Output_all VSS_array simp_DFF
x47 VDD_array Rst_output_DFFs N3_out N3_cap Output_all VSS_array simp_DFF
x48 VDD_array Rst_output_DFFs N2_out N2_cap Output_all VSS_array simp_DFF
x49 VDD_array Rst_output_DFFs N1_out N1_cap Output_all VSS_array simp_DFF
x50 VDD_array Rst_output_DFFs N0_out N0_cap Output_all VSS_array simp_DFF
x51 VDD_array Ck0 CLK_comp Valid_DFF Comp VSS_array simp_NOR3
x1 VDD_array CompB Valid_DFF S9 VSS_array Sn9 Ck9 simp_DFF_yannan
x2 VDD_array S9 Valid_DFF S8 VSS_array Sn8 Ck8 simp_DFF_yannan
x3 VDD_array S8 Valid_DFF S7 VSS_array Sn7 Ck7 simp_DFF_yannan
x4 VDD_array S7 Valid_DFF S6 VSS_array Sn6 Ck6 simp_DFF_yannan
x5 VDD_array S6 Valid_DFF S5 VSS_array Sn5 Ck5 simp_DFF_yannan
x6 VDD_array S5 Valid_DFF S4 VSS_array Sn4 Ck4 simp_DFF_yannan
x7 VDD_array S4 Valid_DFF S3 VSS_array Sn3 Ck3 simp_DFF_yannan
x8 VDD_array S3 Valid_DFF S2 VSS_array Sn2 Ck2 simp_DFF_yannan
x9 VDD_array S2 Valid_DFF S1 VSS_array Sn1 Ck1 simp_DFF_yannan
x10 VDD_array S1 Valid_DFF S0 VSS_array Sn0 Ck0 simp_DFF_yannan
x52 VDD_array Reset_decision N9_cap Comp_outN Ck9 VSS_array simp_DFF
x53 VDD_array Reset_decision N8_cap Comp_outN Ck8 VSS_array simp_DFF
x54 VDD_array Reset_decision N7_cap Comp_outN Ck7 VSS_array simp_DFF
x55 VDD_array Reset_decision N6_cap Comp_outN Ck6 VSS_array simp_DFF
x56 VDD_array Reset_decision N5_cap Comp_outN Ck5 VSS_array simp_DFF
x57 VDD_array Reset_decision N4_cap Comp_outN Ck4 VSS_array simp_DFF
x58 VDD_array Reset_decision N3_cap Comp_outN Ck3 VSS_array simp_DFF
x59 VDD_array Reset_decision N2_cap Comp_outN Ck2 VSS_array simp_DFF
x60 VDD_array Reset_decision N1_cap Comp_outN Ck1 VSS_array simp_DFF
x61 VDD_array Reset_decision N0_cap Comp_outN Ck0 VSS_array simp_DFF
x21 VDD_array Rst_output_DFFs P9_out P9_cap Output_all VSS_array simp_DFF
x22 VDD_array Rst_output_DFFs P8_out P8_cap Output_all VSS_array simp_DFF
x23 VDD_array Rst_output_DFFs P7_out P7_cap Output_all VSS_array simp_DFF
x24 VDD_array Rst_output_DFFs P6_out P6_cap Output_all VSS_array simp_DFF
x25 VDD_array Rst_output_DFFs P5_out P5_cap Output_all VSS_array simp_DFF
x26 VDD_array Rst_output_DFFs P4_out P4_cap Output_all VSS_array simp_DFF
x27 VDD_array Rst_output_DFFs P3_out P3_cap Output_all VSS_array simp_DFF
x28 VDD_array Rst_output_DFFs P2_out P2_cap Output_all VSS_array simp_DFF
x29 VDD_array Rst_output_DFFs P1_out P1_cap Output_all VSS_array simp_DFF
x30 VDD_array Rst_output_DFFs P0_out P0_cap Output_all VSS_array simp_DFF
.ends

* expanding   symbol:  capDrivers.sym # of pins=22
** sym_path: /foss/designs/capDrivers.sym
** sch_path: /foss/designs/capDrivers.sch
.subckt capDrivers VDD Drv9 In9 Drv8 In8 Drv7 In7 Drv6 In6 Drv5 In5 In4 Drv4 Drv3 In3 In2 Drv2 In1 Drv1 Drv0 In0 VSS
*.iopin VDD
*.iopin VSS
*.opin Drv9
*.opin Drv8
*.opin Drv7
*.opin Drv6
*.opin Drv5
*.opin Drv4
*.opin Drv3
*.opin Drv2
*.opin Drv1
*.opin Drv0
*.ipin In9
*.ipin In8
*.ipin In7
*.ipin In6
*.ipin In5
*.ipin In4
*.ipin In3
*.ipin In2
*.ipin In1
*.ipin In0
XM1 Drv9 net1 VDD VDD sg13_lv_pmos w=0.15u l=0.13u ng=1 m=8 mm_ok=1
XM2 Drv9 net1 VSS VSS sg13_lv_nmos w=0.15u l=0.13u ng=1 m=8 mm_ok=1
XM3 Drv8 net2 VDD VDD sg13_lv_pmos w=0.15u l=0.13u ng=1 m=8 mm_ok=1
XM4 Drv8 net2 VSS VSS sg13_lv_nmos w=0.15u l=0.13u ng=1 m=8 mm_ok=1
XM5 Drv7 net3 VDD VDD sg13_lv_pmos w=0.15u l=0.13u ng=1 m=8 mm_ok=1
XM6 Drv7 net3 VSS VSS sg13_lv_nmos w=0.15u l=0.13u ng=1 m=8 mm_ok=1
XM7 Drv6 net4 VDD VDD sg13_lv_pmos w=0.15u l=0.13u ng=1 m=4 mm_ok=1
XM8 Drv6 net4 VSS VSS sg13_lv_nmos w=0.15u l=0.13u ng=1 m=4 mm_ok=1
XM9 Drv5 net5 VDD VDD sg13_lv_pmos w=0.15u l=0.13u ng=1 m=4 mm_ok=1
XM10 Drv5 net5 VSS VSS sg13_lv_nmos w=0.15u l=0.13u ng=1 m=4 mm_ok=1
XM11 Drv4 net6 VDD VDD sg13_lv_pmos w=0.15u l=0.13u ng=1 m=4 mm_ok=1
XM12 Drv4 net6 VSS VSS sg13_lv_nmos w=0.15u l=0.13u ng=1 m=4 mm_ok=1
XM13 Drv3 net7 VDD VDD sg13_lv_pmos w=0.15u l=0.13u ng=1 m=2 mm_ok=1
XM14 Drv3 net7 VSS VSS sg13_lv_nmos w=0.15u l=0.13u ng=1 m=2 mm_ok=1
XM15 Drv2 net8 VDD VDD sg13_lv_pmos w=0.15u l=0.13u ng=1 m=2 mm_ok=1
XM16 Drv2 net8 VSS VSS sg13_lv_nmos w=0.15u l=0.13u ng=1 m=2 mm_ok=1
XM17 Drv1 net9 VDD VDD sg13_lv_pmos w=0.15u l=0.13u ng=1 m=2 mm_ok=1
XM18 Drv1 net9 VSS VSS sg13_lv_nmos w=0.15u l=0.13u ng=1 m=2 mm_ok=1
XM19 Drv0 net10 VDD VDD sg13_lv_pmos w=0.15u l=0.13u ng=1 m=1 mm_ok=1
XM20 Drv0 net10 VSS VSS sg13_lv_nmos w=0.15u l=0.13u ng=1 m=1 mm_ok=1
XM31 net8 In2 VDD VDD sg13_lv_pmos w=0.15u l=0.13u ng=1 m=2 mm_ok=1
XM32 net8 In2 VSS VSS sg13_lv_nmos w=0.15u l=0.13u ng=1 m=2 mm_ok=1
XM33 net9 In1 VDD VDD sg13_lv_pmos w=0.15u l=0.13u ng=1 m=2 mm_ok=1
XM34 net9 In1 VSS VSS sg13_lv_nmos w=0.15u l=0.13u ng=1 m=2 mm_ok=1
XM35 net10 In0 VDD VDD sg13_lv_pmos w=0.15u l=0.13u ng=1 m=1 mm_ok=1
XM36 net10 In0 VSS VSS sg13_lv_nmos w=0.15u l=0.13u ng=1 m=1 mm_ok=1
XM21 net5 In5 VDD VDD sg13_lv_pmos w=0.15u l=0.13u ng=1 m=2 mm_ok=1
XM22 net5 In5 VSS VSS sg13_lv_nmos w=0.15u l=0.13u ng=1 m=2 mm_ok=1
XM23 net6 In4 VDD VDD sg13_lv_pmos w=0.15u l=0.13u ng=1 m=2 mm_ok=1
XM24 net6 In4 VSS VSS sg13_lv_nmos w=0.15u l=0.13u ng=1 m=2 mm_ok=1
XM25 net7 In3 VDD VDD sg13_lv_pmos w=0.15u l=0.13u ng=1 m=1 mm_ok=1
XM26 net7 In3 VSS VSS sg13_lv_nmos w=0.15u l=0.13u ng=1 m=1 mm_ok=1
XM27 net4 In6 VDD VDD sg13_lv_pmos w=0.15u l=0.13u ng=1 m=2 mm_ok=1
XM28 net4 In6 VSS VSS sg13_lv_nmos w=0.15u l=0.13u ng=1 m=2 mm_ok=1
XM29 net1 In9 VDD VDD sg13_lv_pmos w=0.15u l=0.13u ng=1 m=2 mm_ok=1
XM30 net1 In9 VSS VSS sg13_lv_nmos w=0.15u l=0.13u ng=1 m=2 mm_ok=1
XM37 net2 In8 VDD VDD sg13_lv_pmos w=0.15u l=0.13u ng=1 m=2 mm_ok=1
XM38 net2 In8 VSS VSS sg13_lv_nmos w=0.15u l=0.13u ng=1 m=2 mm_ok=1
XM39 net3 In7 VDD VDD sg13_lv_pmos w=0.15u l=0.13u ng=1 m=1 mm_ok=1
XM40 net3 In7 VSS VSS sg13_lv_nmos w=0.15u l=0.13u ng=1 m=1 mm_ok=1
.ends

* expanding   symbol:  simp_DFF.sym # of pins=6
** sym_path: /foss/designs/simp_DFF.sym
** sch_path: /foss/designs/simp_DFF.sch
.subckt simp_DFF VDD_DFF Rst_DFF out_DFF in_DFF CLK_DFF VSS_DFF
*.ipin in_DFF
*.ipin CLK_DFF
*.ipin Rst_DFF
*.opin out_DFF
*.iopin VDD_DFF
*.iopin VSS_DFF
XM1 net1 in_DFF VSS_DFF VSS_DFF sg13_hv_nmos w=0.3u l=0.45u ng=1 m=1 mm_ok=1
XM2 net1 CLK_DFF net2 VDD_DFF sg13_hv_pmos w=0.3u l=0.4u ng=1 m=1 mm_ok=1
XM3 net2 in_DFF VDD_DFF VDD_DFF sg13_hv_pmos w=0.3u l=0.4u ng=1 m=1 mm_ok=1
XM4 net3 CLK_DFF VSS_DFF VSS_DFF sg13_hv_nmos w=0.3u l=0.45u ng=1 m=1 mm_ok=1
XM5 net5 net1 net3 VSS_DFF sg13_hv_nmos w=0.3u l=0.45u ng=1 m=1 mm_ok=1
XM6 net4 CLK_DFF VDD_DFF VDD_DFF sg13_hv_pmos w=0.3u l=0.4u ng=1 m=1 mm_ok=1
XM7 net5 Rst_DFF net4 VDD_DFF sg13_hv_pmos w=0.3u l=0.4u ng=1 m=1 mm_ok=1
XM8 net5 Rst_DFF VSS_DFF VSS_DFF sg13_hv_nmos w=0.3u l=0.45u ng=1 m=1 mm_ok=1
XM9 net5 net7 VDD_DFF VDD_DFF sg13_hv_pmos w=0.3u l=0.4u ng=1 m=1 mm_ok=1
XM10 net9 net5 VSS_DFF VSS_DFF sg13_hv_nmos w=0.3u l=0.45u ng=1 m=1 mm_ok=1
XM11 net7 net5 VDD_DFF VDD_DFF sg13_hv_pmos w=0.3u l=0.4u ng=1 m=1 mm_ok=1
XM12 net7 out_DFF VDD_DFF VDD_DFF sg13_hv_pmos w=0.3u l=0.4u ng=1 m=1 mm_ok=1
XM13 net7 out_DFF net6 VSS_DFF sg13_hv_nmos w=0.3u l=0.45u ng=1 m=1 mm_ok=1
XM14 net6 net5 VSS_DFF VSS_DFF sg13_hv_nmos w=0.3u l=0.45u ng=1 m=1 mm_ok=1
XM15 net8 net5 VDD_DFF VDD_DFF sg13_hv_pmos w=0.3u l=0.4u ng=1 m=1 mm_ok=1
XM16 net8 CLK_DFF net9 VSS_DFF sg13_hv_nmos w=0.3u l=0.45u ng=1 m=1 mm_ok=1
XM17 out_DFF net8 VDD_DFF VDD_DFF sg13_hv_pmos w=0.3u l=0.4u ng=1 m=1 mm_ok=1
XM18 out_DFF net8 VSS_DFF VSS_DFF sg13_hv_nmos w=0.3u l=0.45u ng=1 m=1 mm_ok=1
XM19 out_DFF Rst_DFF VSS_DFF VSS_DFF sg13_hv_nmos w=0.3u l=0.45u ng=1 m=1 mm_ok=1
.ends

* expanding   symbol:  simp_NOR3.sym # of pins=6
** sym_path: /foss/designs/simp_NOR3.sym
** sch_path: /foss/designs/simp_NOR3.sch
.subckt simp_NOR3 VDD_NOR3 A NOR_out C B VSS_NOR3
*.iopin VDD_NOR3
*.iopin VSS_NOR3
*.opin NOR_out
*.ipin A
*.ipin B
*.ipin C
XM1 net2 A VDD_NOR3 VDD_NOR3 sg13_hv_pmos w=0.3u l=0.4u ng=1 m=1 mm_ok=1
XM2 net1 B net2 VDD_NOR3 sg13_hv_pmos w=0.3u l=0.4u ng=1 m=1 mm_ok=1
XM3 NOR_out C net1 VDD_NOR3 sg13_hv_pmos w=0.3u l=0.4u ng=1 m=1 mm_ok=1
XM4 NOR_out C VSS_NOR3 VSS_NOR3 sg13_hv_nmos w=0.3u l=0.45u ng=1 m=1 mm_ok=1
XM5 NOR_out A VSS_NOR3 VSS_NOR3 sg13_hv_nmos w=0.3u l=0.45u ng=1 m=1 mm_ok=1
XM6 NOR_out B VSS_NOR3 VSS_NOR3 sg13_hv_nmos w=0.3u l=0.45u ng=1 m=1 mm_ok=1
.ends

* expanding   symbol:  simp_DFF_yannan.sym # of pins=7
** sym_path: /foss/designs/simp_DFF_yannan.sym
** sch_path: /foss/designs/simp_DFF_yannan.sch
.subckt simp_DFF_yannan VDD_CKc Rst_CKc CKc Sn VSS_CKc SCn CLKn
*.ipin CKc
*.ipin Rst_CKc
*.iopin VDD_CKc
*.iopin VSS_CKc
*.opin Sn
*.opin SCn
*.opin CLKn
XM1 net2 Rst_CKc VSS_CKc VSS_CKc sg13_hv_nmos w=0.3u l=0.45u ng=1 m=1 mm_ok=1
XM3 net1 Rst_CKc VDD_CKc VDD_CKc sg13_hv_pmos w=0.3u l=0.4u ng=1 m=1 mm_ok=1
XM12 net3 net1 VDD_CKc VDD_CKc sg13_hv_pmos w=0.3u l=0.4u ng=1 m=1 mm_ok=1
XM10 Sn net1 VSS_CKc VSS_CKc sg13_hv_nmos w=0.3u l=0.45u ng=1 m=1 mm_ok=1
XM2 net1 CKc net2 VSS_CKc sg13_hv_nmos w=0.3u l=0.45u ng=1 m=1 mm_ok=1
XM4 Sn CKc net3 VDD_CKc sg13_hv_pmos w=0.3u l=0.4u ng=1 m=1 mm_ok=1
XM5 net4 Sn VDD_CKc VDD_CKc sg13_hv_pmos w=0.3u l=0.4u ng=1 m=1 mm_ok=1
XM6 net4 Sn VSS_CKc VSS_CKc sg13_hv_nmos w=0.3u l=0.45u ng=1 m=1 mm_ok=1
XM11 SCn net4 VDD_CKc VDD_CKc sg13_hv_pmos w=0.3u l=0.4u ng=1 m=1 mm_ok=1
XM7 SCn Rst_CKc VDD_CKc VDD_CKc sg13_hv_pmos w=0.3u l=0.4u ng=1 m=1 mm_ok=1
XM13 SCn Rst_CKc net5 VSS_CKc sg13_hv_nmos w=0.3u l=0.45u ng=1 m=1 mm_ok=1
XM14 net5 net4 VSS_CKc VSS_CKc sg13_hv_nmos w=0.3u l=0.45u ng=1 m=1 mm_ok=1
XM8 CLKn net1 VSS_CKc VSS_CKc sg13_hv_nmos w=0.3u l=0.45u ng=1 m=1 mm_ok=1
XM9 CLKn SCn VSS_CKc VSS_CKc sg13_hv_nmos w=0.3u l=0.45u ng=1 m=1 mm_ok=1
XM15 CLKn SCn net6 VDD_CKc sg13_hv_pmos w=0.3u l=0.4u ng=1 m=1 mm_ok=1
XM16 net6 net1 VDD_CKc VDD_CKc sg13_hv_pmos w=0.3u l=0.4u ng=1 m=1 mm_ok=1
.ends

.end
