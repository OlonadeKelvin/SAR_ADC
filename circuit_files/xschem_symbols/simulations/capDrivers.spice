** sch_path: /home/arjun/eda/projects/SAR_ADC/circuit_files/xschem_symbols/capDrivers.sch
**.subckt capDrivers VDD Drv9 In9 Drv8 In8 Drv7 In7 Drv6 In6 Drv5 In5 In4 Drv4 Drv3 In3 In2 Drv2 In1 Drv1 Drv0 In0 VSS
*.iopin VDD
*.iopin VSS
*.opin Drv9
*.opin Drv8
*.opin Drv7
*.opin Drv6
*.opin Drv5
*.opin Drv4
*.opin Drv3
*.opin Drv2
*.opin Drv1
*.opin Drv0
*.ipin In9
*.ipin In8
*.ipin In7
*.ipin In6
*.ipin In5
*.ipin In4
*.ipin In3
*.ipin In2
*.ipin In1
*.ipin In0
XM1 Drv9 net1 VDD VDD sg13_lv_pmos w=0.15u l=0.13u ng=1 m=8 mm_ok=1
XM2 Drv9 net1 VSS VSS sg13_lv_nmos w=0.15u l=0.13u ng=1 m=8 mm_ok=1
XM3 Drv8 net2 VDD VDD sg13_lv_pmos w=0.15u l=0.13u ng=1 m=8 mm_ok=1
XM4 Drv8 net2 VSS VSS sg13_lv_nmos w=0.15u l=0.13u ng=1 m=8 mm_ok=1
XM5 Drv7 net3 VDD VDD sg13_lv_pmos w=0.15u l=0.13u ng=1 m=8 mm_ok=1
XM6 Drv7 net3 VSS VSS sg13_lv_nmos w=0.15u l=0.13u ng=1 m=8 mm_ok=1
XM7 Drv6 net4 VDD VDD sg13_lv_pmos w=0.15u l=0.13u ng=1 m=4 mm_ok=1
XM8 Drv6 net4 VSS VSS sg13_lv_nmos w=0.15u l=0.13u ng=1 m=4 mm_ok=1
XM9 Drv5 net5 VDD VDD sg13_lv_pmos w=0.15u l=0.13u ng=1 m=4 mm_ok=1
XM10 Drv5 net5 VSS VSS sg13_lv_nmos w=0.15u l=0.13u ng=1 m=4 mm_ok=1
XM11 Drv4 net6 VDD VDD sg13_lv_pmos w=0.15u l=0.13u ng=1 m=4 mm_ok=1
XM12 Drv4 net6 VSS VSS sg13_lv_nmos w=0.15u l=0.13u ng=1 m=4 mm_ok=1
XM13 Drv3 net7 VDD VDD sg13_lv_pmos w=0.15u l=0.13u ng=1 m=2 mm_ok=1
XM14 Drv3 net7 VSS VSS sg13_lv_nmos w=0.15u l=0.13u ng=1 m=2 mm_ok=1
XM15 Drv2 net8 VDD VDD sg13_lv_pmos w=0.15u l=0.13u ng=1 m=2 mm_ok=1
XM16 Drv2 net8 VSS VSS sg13_lv_nmos w=0.15u l=0.13u ng=1 m=2 mm_ok=1
XM17 Drv1 net9 VDD VDD sg13_lv_pmos w=0.15u l=0.13u ng=1 m=2 mm_ok=1
XM18 Drv1 net9 VSS VSS sg13_lv_nmos w=0.15u l=0.13u ng=1 m=2 mm_ok=1
XM19 Drv0 net10 VDD VDD sg13_lv_pmos w=0.15u l=0.13u ng=1 m=1 mm_ok=1
XM20 Drv0 net10 VSS VSS sg13_lv_nmos w=0.15u l=0.13u ng=1 m=1 mm_ok=1
XM31 net8 In2 VDD VDD sg13_lv_pmos w=0.15u l=0.13u ng=1 m=2 mm_ok=1
XM32 net8 In2 VSS VSS sg13_lv_nmos w=0.15u l=0.13u ng=1 m=2 mm_ok=1
XM33 net9 In1 VDD VDD sg13_lv_pmos w=0.15u l=0.13u ng=1 m=2 mm_ok=1
XM34 net9 In1 VSS VSS sg13_lv_nmos w=0.15u l=0.13u ng=1 m=2 mm_ok=1
XM35 net10 In0 VDD VDD sg13_lv_pmos w=0.15u l=0.13u ng=1 m=1 mm_ok=1
XM36 net10 In0 VSS VSS sg13_lv_nmos w=0.15u l=0.13u ng=1 m=1 mm_ok=1
XM21 net5 In5 VDD VDD sg13_lv_pmos w=0.15u l=0.13u ng=1 m=2 mm_ok=1
XM22 net5 In5 VSS VSS sg13_lv_nmos w=0.15u l=0.13u ng=1 m=2 mm_ok=1
XM23 net6 In4 VDD VDD sg13_lv_pmos w=0.15u l=0.13u ng=1 m=2 mm_ok=1
XM24 net6 In4 VSS VSS sg13_lv_nmos w=0.15u l=0.13u ng=1 m=2 mm_ok=1
XM25 net7 In3 VDD VDD sg13_lv_pmos w=0.15u l=0.13u ng=1 m=1 mm_ok=1
XM26 net7 In3 VSS VSS sg13_lv_nmos w=0.15u l=0.13u ng=1 m=1 mm_ok=1
XM27 net4 In6 VDD VDD sg13_lv_pmos w=0.15u l=0.13u ng=1 m=2 mm_ok=1
XM28 net4 In6 VSS VSS sg13_lv_nmos w=0.15u l=0.13u ng=1 m=2 mm_ok=1
XM29 net1 In9 VDD VDD sg13_lv_pmos w=0.15u l=0.13u ng=1 m=2 mm_ok=1
XM30 net1 In9 VSS VSS sg13_lv_nmos w=0.15u l=0.13u ng=1 m=2 mm_ok=1
XM37 net2 In8 VDD VDD sg13_lv_pmos w=0.15u l=0.13u ng=1 m=2 mm_ok=1
XM38 net2 In8 VSS VSS sg13_lv_nmos w=0.15u l=0.13u ng=1 m=2 mm_ok=1
XM39 net3 In7 VDD VDD sg13_lv_pmos w=0.15u l=0.13u ng=1 m=1 mm_ok=1
XM40 net3 In7 VSS VSS sg13_lv_nmos w=0.15u l=0.13u ng=1 m=1 mm_ok=1
**.ends
.end
