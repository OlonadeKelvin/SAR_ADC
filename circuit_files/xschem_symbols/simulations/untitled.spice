** sch_path: /home/arjun/eda/projects/SAR_ADC/circuit_files/xschem_symbols/untitled.sch
**.subckt untitled
V_VIN Vinn GND dc {VCM - VDIFF/2}
VDD_SRC vdd GND dc {VDD}
V_VINP Vinp GND dc {VCM + VDIFF/2}
V_VSS vss GND dc 0
V_CLK CLK GND PULSE(0 {VDD} 1n 20p 20p 3n 6n)
COUT Voutp GND {CLOAD}
COUT1 Voutn GND {CLOAD}
x1 vdd CLK Voutn Voutp net1 net2 Vinp Vinn vss simple_comparator
**** begin user architecture code

.param VDD=3.3
.param VCM=1.65
.param VREF=3.3
.param NBITS=10
.param VLSB=3.22265625e-3
.param VHLSB=1.611328125e-3
.param VDIFF=10e-3
.param CLOAD=20f

.options savecurrents
.options reltol=1e-4 abstol=1e-12 vntol=1e-6 method=gear

.save v(CLK) v(Vinp) v(Vinn) v(Voutp) v(Voutn)
.save v(x1.x) v(x1.y) v(x1.p) v(x1.q) v(x1.net1) v(x1.net2) v(x1.net3)
.save i(VDD_SRC)

.control
set filetype=binary

shell rm -f strongarm_results.txt
shell rm -f strongarm_tran_nominal.txt
shell rm -f strongarm_lsb_sweep.txt
shell rm -f strongarm_delay_sweep.txt
shell rm -f strongarm_vcm_sweep.txt
shell rm -f strongarm_vdd_sweep.txt

echo ============================================= > strongarm_results.txt
echo GF180MCU StrongARM comparator qualification >> strongarm_results.txt
echo For 10-bit SAR ADC check >> strongarm_results.txt
echo ============================================= >> strongarm_results.txt
echo . >> strongarm_results.txt
echo Assumed VREF = 3.3 V >> strongarm_results.txt
echo 10-bit LSB  = 3.22265625 mV >> strongarm_results.txt
echo 0.5 LSB     = 1.611328125 mV >> strongarm_results.txt
echo . >> strongarm_results.txt

****************************************************
* 1. Nominal transient at VDIFF = +10 mV
****************************************************

alterparam VDD=3.3
alterparam VCM=1.65
alterparam VDIFF=10e-3
reset

op
tran 1p 5n
write strong_arm_comp_tb.raw

meas tran voutp_samp FIND v(Voutp) AT=4n
meas tran voutn_samp FIND v(Voutn) AT=4n
meas tran x_samp     FIND v(x1.x)     AT=4n
meas tran y_samp     FIND v(x1.y)     AT=4n
meas tran p_samp     FIND v(x1.p)     AT=4n
meas tran q_samp     FIND v(x1.q)     AT=4n
meas tran net1_samp  FIND v(x1.net1)  AT=4n
meas tran net2_samp  FIND v(x1.net2)  AT=4n
meas tran net3_samp  FIND v(x1.net3)  AT=4n

meas tran idd_avg    AVG i(VDD_SRC) FROM=0n TO=5n
meas tran idd_eval   AVG i(VDD_SRC) FROM=1n TO=4n

let vod_samp = voutp_samp - voutn_samp
let pavg = -3.3*idd_avg
let peval = -3.3*idd_eval
let e_5ns = pavg*5n
let e_eval = peval*3n

meas tran t_clk_rise WHEN v(CLK)=1.65 RISE=1
meas tran t_voutn_fall WHEN v(Voutn)=1.65 FALL=1
let td_pos = t_voutn_fall - t_clk_rise

echo ---- Nominal transient result, VDIFF = +10 mV ---- >> strongarm_results.txt
echo Voutp_4ns          = $&voutp_samp V >> strongarm_results.txt
echo Voutn_4ns          = $&voutn_samp V >> strongarm_results.txt
echo Voutp_minus_Voutn  = $&vod_samp   V >> strongarm_results.txt
echo X_4ns              = $&x_samp     V >> strongarm_results.txt
echo Y_4ns              = $&y_samp     V >> strongarm_results.txt
echo P_4ns              = $&p_samp     V >> strongarm_results.txt
echo Q_4ns              = $&q_samp     V >> strongarm_results.txt
echo net1_4ns           = $&net1_samp  V >> strongarm_results.txt
echo net2_4ns           = $&net2_samp  V >> strongarm_results.txt
echo net3_4ns           = $&net3_samp  V >> strongarm_results.txt
echo IDD_avg_0_to_5ns   = $&idd_avg    A >> strongarm_results.txt
echo Pavg_0_to_5ns      = $&pavg       W >> strongarm_results.txt
echo E_0_to_5ns         = $&e_5ns      J >> strongarm_results.txt
echo IDD_eval_1_to_4ns  = $&idd_eval   A >> strongarm_results.txt
echo Peval_1_to_4ns     = $&peval      W >> strongarm_results.txt
echo Eeval_1_to_4ns     = $&e_eval     J >> strongarm_results.txt
echo t_clk_rise         = $&t_clk_rise     s >> strongarm_results.txt
echo t_voutn_fall       = $&t_voutn_fall   s >> strongarm_results.txt
echo td_pos             = $&td_pos         s >> strongarm_results.txt
echo . >> strongarm_results.txt

wrdata strongarm_tran_nominal.txt time v(CLK) v(Vinp) v(Vinn) v(Voutp) v(Voutn) v(x1.x) v(x1.y) v(x1.p) v(x1.q) v(x1.net1) v(x1.net2) v(x1.net3) i(VDD_SRC)
****************************************************
* 2. 10-bit LSB decision sweep
****************************************************

echo ============================================= > strongarm_lsb_sweep.txt
echo 10-bit SAR LSB decision sweep >> strongarm_lsb_sweep.txt
echo VREF = 3.3 V, LSB = 3.22265625 mV, 0.5LSB = 1.611328125 mV >> strongarm_lsb_sweep.txt
echo columns: VDIFF Voutp Voutn Vod X Y P Q net1 net2 net3 Pavg >> strongarm_lsb_sweep.txt
echo ============================================= >> strongarm_lsb_sweep.txt

foreach dv -10e-3 -5e-3 -3.22265625e-3 -1.611328125e-3 -1e-3 -500e-6 500e-6 1e-3 1.611328125e-3 3.22265625e-3 5e-3 10e-3
  alterparam VDD=3.3
  alterparam VCM=1.65
  alterparam VDIFF=$dv
  reset
  tran 1p 5n

  meas tran vop FIND v(Voutp) AT=4n
  meas tran von FIND v(Voutn) AT=4n
  meas tran vx  FIND v(x1.x)     AT=4n
meas tran vy  FIND v(x1.y)     AT=4n
meas tran vp  FIND v(x1.p)     AT=4n
meas tran vq  FIND v(x1.q)     AT=4n
meas tran vn1 FIND v(x1.net1)  AT=4n
meas tran vn2 FIND v(x1.net2)  AT=4n
meas tran vn3 FIND v(x1.net3)  AT=4n
  meas tran ia  AVG i(VDD_SRC) FROM=0n TO=5n

  let vod = vop - von
  let ppwr = -3.3*ia

  echo $dv $&vop $&von $&vod $&vx $&vy $&vp $&vq $&vn1 $&vn2 $&vn3 $&ppwr >> strongarm_lsb_sweep.txt
end

****************************************************
* 3. Delay versus positive VDIFF
****************************************************

echo ============================================= > strongarm_delay_sweep.txt
echo Delay versus positive VDIFF >> strongarm_delay_sweep.txt
echo columns: VDIFF tclk tout td Voutp4n Voutn4n Pavg >> strongarm_delay_sweep.txt
echo ============================================= >> strongarm_delay_sweep.txt

foreach dv 500e-6 1e-3 1.611328125e-3 3.22265625e-3 5e-3 10e-3 20e-3 50e-3
  alterparam VDD=3.3
  alterparam VCM=1.65
  alterparam VDIFF=$dv
  reset
  tran 1p 5n

  meas tran tclk WHEN v(CLK)=1.65 RISE=1
  meas tran tout WHEN v(Voutn)=1.65 FALL=1
  let td = tout - tclk

  meas tran vop4 FIND v(Voutp) AT=4n
  meas tran von4 FIND v(Voutn) AT=4n
  meas tran ia AVG i(VDD_SRC) FROM=0n TO=5n
  let ppwr = -3.3*ia

  echo $dv $&tclk $&tout $&td $&vop4 $&von4 $&ppwr >> strongarm_delay_sweep.txt
end

****************************************************
* 4. Input common-mode sweep at +0.5 LSB
****************************************************

echo ============================================= > strongarm_vcm_sweep.txt
echo VCM sweep at VDIFF = +0.5 LSB >> strongarm_vcm_sweep.txt
echo columns: VCM Voutp4n Voutn4n Vod4n td Pavg >> strongarm_vcm_sweep.txt
echo ============================================= >> strongarm_vcm_sweep.txt

foreach cm 0.8 1.0 1.2 1.4 1.65 1.8 2.0 2.2 2.4
  alterparam VDD=3.3
  alterparam VCM=$cm
  alterparam VDIFF=1.611328125e-3
  reset
  tran 1p 5n

  meas tran vop4 FIND v(Voutp) AT=4n
  meas tran von4 FIND v(Voutn) AT=4n
  let vod4 = vop4 - von4

  meas tran tclk WHEN v(CLK)=1.65 RISE=1
  meas tran tout WHEN v(Voutn)=1.65 FALL=1
  let td = tout - tclk

  meas tran ia AVG i(VDD_SRC) FROM=0n TO=5n
  let ppwr = -3.3*ia

  echo $cm $&vop4 $&von4 $&vod4 $&td $&ppwr >> strongarm_vcm_sweep.txt
end

****************************************************
* 5. Supply sweep at +0.5 LSB
****************************************************

echo ============================================= > strongarm_vdd_sweep.txt
echo VDD sweep at VCM=VDD/2 and VDIFF=+0.5LSB >> strongarm_vdd_sweep.txt
echo columns: VDD VCM Voutp4n Voutn4n Vod4n td Pavg >> strongarm_vdd_sweep.txt
echo ============================================= >> strongarm_vdd_sweep.txt

* VDD = 3.0 V, VCM = 1.5 V
alterparam VDD=3.0
alterparam VCM=1.5
alterparam VDIFF=1.611328125e-3
reset
tran 1p 5n
meas tran vop4 FIND v(Voutp) AT=4n
meas tran von4 FIND v(Voutn) AT=4n
let vod4 = vop4 - von4
meas tran tclk WHEN v(CLK)=1.5 RISE=1
meas tran tout WHEN v(Voutn)=1.5 FALL=1
let td = tout - tclk
meas tran ia AVG i(VDD_SRC) FROM=0n TO=5n
let ppwr = -3.0*ia
echo 3.0 1.5 $&vop4 $&von4 $&vod4 $&td $&ppwr >> strongarm_vdd_sweep.txt

* VDD = 3.15 V, VCM = 1.575 V
alterparam VDD=3.15
alterparam VCM=1.575
alterparam VDIFF=1.611328125e-3
reset
tran 1p 5n
meas tran vop4 FIND v(Voutp) AT=4n
meas tran von4 FIND v(Voutn) AT=4n
let vod4 = vop4 - von4
meas tran tclk WHEN v(CLK)=1.575 RISE=1
meas tran tout WHEN v(Voutn)=1.575 FALL=1
let td = tout - tclk
meas tran ia AVG i(VDD_SRC) FROM=0n TO=5n
let ppwr = -3.15*ia
echo 3.15 1.575 $&vop4 $&von4 $&vod4 $&td $&ppwr >> strongarm_vdd_sweep.txt

* VDD = 3.3 V, VCM = 1.65 V
alterparam VDD=3.3
alterparam VCM=1.65
alterparam VDIFF=1.611328125e-3
reset
tran 1p 5n
meas tran vop4 FIND v(Voutp) AT=4n
meas tran von4 FIND v(Voutn) AT=4n
let vod4 = vop4 - von4
meas tran tclk WHEN v(CLK)=1.65 RISE=1
meas tran tout WHEN v(Voutn)=1.65 FALL=1
let td = tout - tclk
meas tran ia AVG i(VDD_SRC) FROM=0n TO=5n
let ppwr = -3.3*ia
echo 3.3 1.65 $&vop4 $&von4 $&vod4 $&td $&ppwr >> strongarm_vdd_sweep.txt

* VDD = 3.45 V, VCM = 1.725 V
alterparam VDD=3.45
alterparam VCM=1.725
alterparam VDIFF=1.611328125e-3
reset
tran 1p 5n
meas tran vop4 FIND v(Voutp) AT=4n
meas tran von4 FIND v(Voutn) AT=4n
let vod4 = vop4 - von4
meas tran tclk WHEN v(CLK)=1.725 RISE=1
meas tran tout WHEN v(Voutn)=1.725 FALL=1
let td = tout - tclk
meas tran ia AVG i(VDD_SRC) FROM=0n TO=5n
let ppwr = -3.45*ia
echo 3.45 1.725 $&vop4 $&von4 $&vod4 $&td $&ppwr >> strongarm_vdd_sweep.txt

* VDD = 3.6 V, VCM = 1.8 V
alterparam VDD=3.6
alterparam VCM=1.8
alterparam VDIFF=1.611328125e-3
reset
tran 1p 5n
meas tran vop4 FIND v(Voutp) AT=4n
meas tran von4 FIND v(Voutn) AT=4n
let vod4 = vop4 - von4
meas tran tclk WHEN v(CLK)=1.8 RISE=1
meas tran tout WHEN v(Voutn)=1.8 FALL=1
let td = tout - tclk
meas tran ia AVG i(VDD_SRC) FROM=0n TO=5n
let ppwr = -3.6*ia
echo 3.6 1.8 $&vop4 $&von4 $&vod4 $&td $&ppwr >> strongarm_vdd_sweep.txt

echo . >> strongarm_results.txt
echo Additional files generated: >> strongarm_results.txt
echo strongarm_lsb_sweep.txt >> strongarm_results.txt
echo strongarm_delay_sweep.txt >> strongarm_results.txt
echo strongarm_vcm_sweep.txt >> strongarm_results.txt
echo strongarm_vdd_sweep.txt >> strongarm_results.txt

echo Simulation complete.

.endc

?
**** end user architecture code
**.ends

* expanding   symbol:  simple_comparator.sym # of pins=9
** sym_path: /home/arjun/eda/projects/SAR_ADC/circuit_files/xschem_symbols/simple_comparator.sym
** sch_path: /home/arjun/eda/projects/SAR_ADC/circuit_files/xschem_symbols/simple_comparator.sch
.subckt simple_comparator VDD_comparator CLK Voutn Voutp Debug_NC_Vright_gm Debug_NC_Vleft_gm Vinp Vinn VSS_comparator
*.ipin CLK
*.ipin Vinp
*.iopin VSS_comparator
*.iopin VDD_comparator
*.ipin Vinn
*.opin Debug_NC_Vright_gm
*.opin Debug_NC_Vleft_gm
*.opin Voutp
*.opin Voutn
XM1 net2 net1 VDD_comparator VDD_comparator sg13_hv_pmos w=0.3u l=0.4u ng=1 m=1 mm_ok=1
XM2 Debug_NC_Vleft_gm Vinp VS_dp VSS_comparator sg13_hv_nmos w=0.3u l=0.45u ng=1 m=1 mm_ok=1
XM3 net2 net1 Debug_NC_Vleft_gm VSS_comparator sg13_hv_nmos w=0.3u l=0.45u ng=1 m=1 mm_ok=1
XM4 Debug_NC_Vright_gm Vinn VS_dp VSS_comparator sg13_hv_nmos w=0.3u l=0.45u ng=1 m=1 mm_ok=1
XM5 net1 net2 Debug_NC_Vright_gm VSS_comparator sg13_hv_nmos w=0.3u l=0.45u ng=1 m=1 mm_ok=1
XM6 net1 net2 VDD_comparator VDD_comparator sg13_hv_pmos w=0.3u l=0.4u ng=1 m=1 mm_ok=1
XM7 VS_dp CLK VSS_comparator VSS_comparator sg13_hv_nmos w=0.3u l=0.45u ng=1 m=1 mm_ok=1
XM8 net1 CLK VDD_comparator VDD_comparator sg13_hv_pmos w=0.3u l=0.4u ng=1 m=1 mm_ok=1
XM9 net2 CLK VDD_comparator VDD_comparator sg13_hv_pmos w=0.3u l=0.4u ng=1 m=1 mm_ok=1
XM10 net3 net1 VDD_comparator VDD_comparator sg13_hv_pmos w=0.3u l=0.4u ng=1 m=1 mm_ok=1
XM11 net3 net1 VSS_comparator VSS_comparator sg13_hv_nmos w=0.3u l=0.45u ng=1 m=1 mm_ok=1
XM12 Voutn net3 VDD_comparator VDD_comparator sg13_hv_pmos w=0.3u l=0.4u ng=1 m=1 mm_ok=1
XM13 Voutn net3 VSS_comparator VSS_comparator sg13_hv_nmos w=0.3u l=0.45u ng=1 m=1 mm_ok=1
XM14 net4 net2 VDD_comparator VDD_comparator sg13_hv_pmos w=0.3u l=0.4u ng=1 m=1 mm_ok=1
XM15 net4 net2 VSS_comparator VSS_comparator sg13_hv_nmos w=0.3u l=0.45u ng=1 m=1 mm_ok=1
XM16 Voutp net4 VDD_comparator VDD_comparator sg13_hv_pmos w=0.3u l=0.4u ng=1 m=1 mm_ok=1
XM17 Voutp net4 VSS_comparator VSS_comparator sg13_hv_nmos w=0.3u l=0.45u ng=1 m=1 mm_ok=1
.ends

.GLOBAL GND
.end
