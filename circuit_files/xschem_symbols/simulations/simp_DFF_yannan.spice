** sch_path: /home/arjun/eda/projects/SAR_ADC/circuit_files/xschem_symbols/simp_DFF_yannan.sch
**.subckt simp_DFF_yannan VDD_CKc Rst_CKc CKc Sn VSS_CKc SCn CLKn SCnB
*.ipin CKc
*.ipin Rst_CKc
*.iopin VDD_CKc
*.iopin VSS_CKc
*.opin Sn
*.opin SCn
*.opin CLKn
*.opin SCnB
XM1 net2 Rst_CKc VSS_CKc VSS_CKc sg13_hv_nmos w=0.3u l=0.45u ng=1 m=1 mm_ok=1
XM3 net1 Rst_CKc VDD_CKc VDD_CKc sg13_hv_pmos w=0.3u l=0.4u ng=1 m=1 mm_ok=1
XM12 net3 net1 VDD_CKc VDD_CKc sg13_hv_pmos w=0.3u l=0.4u ng=1 m=1 mm_ok=1
XM10 Sn net1 VSS_CKc VSS_CKc sg13_hv_nmos w=0.3u l=0.45u ng=1 m=1 mm_ok=1
XM2 net1 CKc net2 VSS_CKc sg13_hv_nmos w=0.3u l=0.45u ng=1 m=1 mm_ok=1
XM4 Sn CKc net3 VDD_CKc sg13_hv_pmos w=0.3u l=0.4u ng=1 m=1 mm_ok=1
XM5 net4 Sn VDD_CKc VDD_CKc sg13_hv_pmos w=0.3u l=0.4u ng=1 m=1 mm_ok=1
XM6 net4 Sn VSS_CKc VSS_CKc sg13_hv_nmos w=0.3u l=0.45u ng=1 m=1 mm_ok=1
XM11 SCn net4 VDD_CKc VDD_CKc sg13_hv_pmos w=0.3u l=0.4u ng=1 m=1 mm_ok=1
XM7 SCn Rst_CKc VDD_CKc VDD_CKc sg13_hv_pmos w=0.3u l=0.4u ng=1 m=1 mm_ok=1
XM13 SCn Rst_CKc net5 VSS_CKc sg13_hv_nmos w=0.3u l=0.45u ng=1 m=1 mm_ok=1
XM14 net5 net4 VSS_CKc VSS_CKc sg13_hv_nmos w=0.3u l=0.45u ng=1 m=1 mm_ok=1
XM8 CLKn net1 VSS_CKc VSS_CKc sg13_hv_nmos w=0.3u l=0.45u ng=1 m=1 mm_ok=1
XM9 CLKn SCn VSS_CKc VSS_CKc sg13_hv_nmos w=0.3u l=0.45u ng=1 m=1 mm_ok=1
XM15 CLKn SCn net6 VDD_CKc sg13_hv_pmos w=0.3u l=0.4u ng=1 m=1 mm_ok=1
XM16 net6 net1 VDD_CKc VDD_CKc sg13_hv_pmos w=0.3u l=0.4u ng=1 m=1 mm_ok=1
XM17 SCnB SCn VSS_CKc VSS_CKc sg13_lv_nmos w=0.15u l=0.13u ng=1 m=1 mm_ok=1
XM18 SCnB SCn VDD_CKc VDD_CKc sg13_lv_pmos w=0.15u l=0.13u ng=1 m=1 mm_ok=1
**.ends
.end
